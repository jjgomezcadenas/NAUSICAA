* VH1 reset CSA prototype: csa_v3 amplifier core (M1-M6 and biases) without Mf
M1 s in med Vdda 180nmP l=0.5u w=220u m=1
Vdd Vdda 0 1.8
M2 Vdda Vnmos s 0 180nmN l=0.5u w=27u m=3
Vnmos Vnmos 0 1.6
M3 med Vnload 0 0 180nmN l=2u w=200u m=1
Vnload Vnload 0 0.538477478921
M4 med Vncasc out 0 180nmN l=1.44u w=2.88u m=1
M5 vd6 Vp5 out Vdda 180nmP l=0.5u w=220u m=1
M6 Vdda Vp6 vd6 Vdda 180nmP l=6u w=1u m=1
Vp6 Vp6 0 1.1
Vp5 Vp5 0 0.8
Vp1 Vncasc 0 0.6621
Cd1 x 0 1.25p
Voff in x 0
.lib corrected.inc
.temp 20
.options reltol=1e-6 abstol=1e-19 vntol=1e-10 numdgt=15 plotwinsize=0
* gmin=1e-12 would put 1 Tohm across every off switch: 3 ms leak on 3 fF
.options gmin=1e-18
.nodeset V(in)=0.00135 V(x)=0.00135 V(out)=0.886 V(med)=0.184 V(s)=0.836 V(vd6)=1.25
Cf out x 3e-15
Vshift out r 0.885012
Rdc r x 1e15 noiseless
Is1 0 x 0 AC 1
.ac dec 40 1e-3 1e9
.save V(x) V(in) V(out)
.end
